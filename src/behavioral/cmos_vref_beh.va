// Block 2 - CMOS 1.2V-class voltage reference (bandgap-equivalent),
// current-summed (Banba-style) architecture targeting ~1.0V supply.
//
// CORRECTED FROM AN EARLIER HBT-BASED VERSION: this project originally
// assumed SG13G2 (full SiGe BiCMOS, real HBTs available). The actual
// target for this Chipalooza round is ihp-sg13cmos5l - a CMOS-ONLY
// derivative where NPN is unavailable and PNP is uncharacterized (per the
// challenge's own signup form). A bipolar bandgap is not viable here.
//
// Real topology: two MOSFETs biased in WEAK INVERSION (subthreshold) at
// different current densities (area/bias ratio N) generate a PTAT-like
// current I_ptat = n*Vt*ln(N)/R1 via a loop-forcing amplifier (in the real
// schematic, Block 1's ring-amp OTA design, instantiated as its own
// dedicated copy) - "n" is the subthreshold
// slope factor (~1.3-1.5 in 130nm-class CMOS, NOT 1 the way an ideal BJT's
// VBE would be - this is the one place the physics genuinely differs from
// the bipolar version, not just a renamed device). A separate VGS/R2
// branch gives a CTAT current. Both are mirrored into output resistor R3,
// so Vref = R3*(k1*I_ptat + k2*I_ctat) - a resistor ratio, not a series
// voltage stack, which is what keeps the whole loop under 1.0V. This is
// the Banba architecture: H. Banba et al., "A CMOS Bandgap Reference
// Circuit with Sub-1-V Operation," IEEE JSSC, May 1999 - the direct
// citation now, since Malcovati's BiCMOS current-summing paper (still a
// good conceptual reference for the current-summing TRICK itself) assumed
// devices unavailable on this target PDK.
`include "constants.vams"
`include "disciplines.vams"

module cmos_vref_beh(vref, vdd, vss);
    output vref;
    input vdd, vss;
    electrical vref, vdd, vss;

    parameter real n_ratio  = 8;       // MOSFET area/current-density ratio between the two devices
    parameter real n_slope  = 1.4;     // subthreshold slope factor - PLACEHOLDER, calibrate
                                        // against real ihp-sg13cmos5l device models before trusting
    parameter real r1       = 20k;     // ohms, sets I_ptat = n_slope*Vt*ln(N)/R1
    parameter real r2       = 50k;     // ohms, sets I_ctat = Vgs/R2
    parameter real r3       = 20k;     // ohms, output resistor - sets Vref scale (~0.48V nominal)
    parameter real k1       = 2.3917;  // PTAT mirror ratio - solved for first-order TC
                                        // cancellation given r1/r2/tc_vgs/n_slope below; verify
                                        // in src/spice/ before trusting (see bandgap_tc.cir pattern)
    parameter real k2       = 1;       // CTAT mirror ratio
    parameter real vgs0     = 0.75;    // subthreshold-biased Vgs at Tnom (V) - PLACEHOLDER
    parameter real tc_vgs   = 1.5m;    // Vgs temperature coefficient, magnitude (V/K) - PLACEHOLDER
    parameter real tnom     = 300;     // reference temperature (K)

    real vt, vgs, i_ptat, i_ctat;

    analog begin
        vt  = $temperature * `P_K / `P_Q;
        vgs = vgs0 - tc_vgs * ($temperature - tnom);

        i_ptat = n_slope * vt * ln(n_ratio) / r1;
        i_ctat = vgs / r2;

        V(vref) <+ r3 * (k1 * i_ptat + k2 * i_ctat);
    end
endmodule
