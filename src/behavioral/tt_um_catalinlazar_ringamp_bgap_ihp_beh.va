// Top-level behavioral model: tt_um_catalinlazar_ringamp_bgap_ihp
//
// Wires all block-level behavioral models together the same way the real
// tile will be wired. The comparator (Block 0) taps the shared bus
// directly and drives its digital output independent of the mux. Six
// blocks share ua_out through a 3-bit digitally controlled mux, followed
// by a SINGLE shared output buffer instance.
//
// Block-select mapping (sel[2:0] = {sel2, sel1, sel0}; deliberately no
// floating/idle state - the shared bus always has a real, well-defined
// block connected, and every unused code safely defaults to the CMOS
// voltage reference):
//   000 -> CMOS voltage reference (DEFAULT at reset - most tolerant of an
//                               undefined/unknown external load)
//   001 -> Ring-amp OTA
//   010 -> SC bandgap
//   011 -> ZCBC amp           (comparator-based discharge amplifier,
//                               reuses Block 0's design as its own
//                               zero-crossing-detector instance in the
//                               real transistor-level implementation)
//   100 -> FIA (Floating Inverter Amplifier)
//   101 -> Classic OTA        (folded-cascode/telescopic backup for the
//                               eventual cyclic ADC, in case the ring-amp
//                               underperforms in silicon)
//   110 -> CMOS voltage reference (spare, safe default)
//   111 -> CMOS voltage reference (spare, safe default)
//
// NOTE: Block 2 was originally an HBT-based bandgap, assuming SG13G2
// (full BiCMOS). The actual target for this Chipalooza round is
// ihp-sg13cmos5l (CMOS-only, NPN unavailable, PNP uncharacterized per the
// challenge's own signup form) - Block 2 is now a subthreshold-CMOS
// current-summed reference (Banba-style) instead. See cmos_vref_beh.va.
//
// buf_bypass (ui[3]) forces the buffer's input to connect directly to
// ua_in instead of the mux output, for buffer-only characterization -
// deliberately the SAME buffer instance in both cases (not a duplicate
// copy), so buffer non-idealities measured in bypass mode can be
// de-embedded from the block measurements without introducing new
// instance-to-instance mismatch.
//
// ua_raw_sel (ui[4]) selects what actually appears on the ua[1] pad:
// 0 = buffer output (normal), 1 = bare mux output, bypassing the buffer
// entirely. This is a MODE SELECT on the same pin, not a second physical
// pad - a dedicated raw pin would permanently load the mux_out node with
// pad/ESD parasitics (worst for the ring-amp/FIA/ZCBC) even when unused.
//
// Use this for early top-level verification (does the pin map make sense,
// does the mux selection work, do block interactions look reasonable)
// BEFORE transistor-level schematics exist. Replace block instances with
// real subcircuits as each is designed; the port list should not need to
// change.
`include "constants.vams"
`include "disciplines.vams"

module tt_um_catalinlazar_ringamp_bgap_ihp_beh(
    sel0, sel1, sel2, // ui[0], ui[1], ui[5] - mux block select, see mapping above
    comp_clk,         // ui[2] - comparator/ZCBC/SC bandgap clock
    buf_bypass,       // ui[3] - 1: buffer input = ua_in directly (buffer-only characterization)
    ua_raw_sel,       // ui[4] - 1: ua[1] = bare mux output (bypass buffer entirely, debug mode)
    ua_in,            // ua[0] - shared analog input
    ua_out,           // ua[1] - shared analog output: buffer output (normal) or raw mux output (debug)
    ua_ref,           // ua[2] - shared reference/second input
    uo_comp,          // uo[0] - comparator digital output (direct, not muxed, not buffered)
    vdd, vss
);
    input sel0, sel1, sel2, comp_clk, buf_bypass, ua_raw_sel, ua_in, ua_ref, vdd, vss;
    output ua_out, uo_comp;
    electrical sel0, sel1, sel2, comp_clk, buf_bypass, ua_raw_sel, ua_in, ua_out, ua_ref, uo_comp, vdd, vss;

    electrical ringamp_out, cmosvref_out, scbg_out, zcbc_out, fia_out, classic_out;
    electrical mux_out, buf_in, buf_out;

    parameter real vth_dig = 0.6; // digital logic threshold on select/mode pins (V)

    real s0, s1, s2, sbyp, sraw, selcode;

    comparator_beh   U_CMP (.clk(comp_clk), .inp(ua_in), .inn(ua_ref), .out(uo_comp), .vdd(vdd), .vss(vss));
    ringamp_ota_beh  U_RA  (.inp(ua_in), .inn(ua_ref), .out(ringamp_out), .vdd(vdd), .vss(vss));
    cmos_vref_beh    U_VREF(.vref(cmosvref_out), .vdd(vdd), .vss(vss));
    sc_bandgap_beh   U_SC  (.clk(comp_clk), .vref(scbg_out), .vdd(vdd), .vss(vss));
    zcbc_amp_beh     U_ZCBC(.inp(ua_in), .inn(ua_ref), .clk(comp_clk), .out(zcbc_out), .vdd(vdd), .vss(vss));
    fia_ota_beh      U_FIA (.inp(ua_in), .inn(ua_ref), .out(fia_out), .vdd(vdd), .vss(vss));
    classic_ota_beh  U_CLA (.inp(ua_in), .inn(ua_ref), .out(classic_out), .vdd(vdd), .vss(vss));
    buffer_beh       U_BUF (.in(buf_in), .out(buf_out), .vdd(vdd), .vss(vss));

    analog begin
        s0   = (V(sel0) > vth_dig) ? 1 : 0;
        s1   = (V(sel1) > vth_dig) ? 1 : 0;
        s2   = (V(sel2) > vth_dig) ? 1 : 0;
        sbyp = (V(buf_bypass) > vth_dig) ? 1 : 0;
        sraw = (V(ua_raw_sel) > vth_dig) ? 1 : 0;
        selcode = s2 * 4 + s1 * 2 + s0;

        if (selcode == 1)
            V(mux_out) <+ V(ringamp_out);
        else if (selcode == 2)
            V(mux_out) <+ V(scbg_out);
        else if (selcode == 3)
            V(mux_out) <+ V(zcbc_out);
        else if (selcode == 4)
            V(mux_out) <+ V(fia_out);
        else if (selcode == 5)
            V(mux_out) <+ V(classic_out);
        else
            V(mux_out) <+ V(cmosvref_out); // selcode == 0, 6, 7: CMOS voltage reference (safe default)

        V(buf_in) <+ (sbyp > 0) ? V(ua_in) : V(mux_out);

        V(ua_out) <+ (sraw > 0) ? V(mux_out) : V(buf_out);
    end
endmodule
