* Block 2 - CMOS subthreshold voltage reference - temperature sweep
.param n_ratio=8 n_slope=1.4 r1=20k r2=50k r3=20k k1=2.3917 k2=1 vgs0=0.75 tc_vgs=1.5m tnom=300
.param kq=8.617333e-5

Bvref vref 0 V = r3*(k1*(n_slope*kq*(temper+273.15)*ln(n_ratio)/r1) + k2*((vgs0-tc_vgs*((temper+273.15)-tnom))/r2))
Rload vref 0 1meg

.dc TEMP 0 80 1

.control
run
wrdata cmos_vref_tc.txt v(vref)
.endc
.end
